** sch_path: /home/benedikt/heichips26-FAIf/macros/heichips26_FAIf/macros/asw_inv/schematic/xschem/asw_inv.sch
**.subckt asw_inv VDD b a VSS sw
*.iopin a
*.iopin sw
*.iopin VDD
*.iopin b
*.iopin VSS
x1 net1 VDD b a VSS sw aswitch
XMP1 net1 sw VDD VDD sg13_hv_pmos w=0.6u l=0.45u ng=1 m=1 mm_ok=1
XMN1 net1 sw VSS VSS sg13_hv_nmos w=0.3u l=0.45u ng=1 m=1 mm_ok=1
**.ends

* expanding   symbol:  aswitch.sym # of pins=6
** sym_path: /home/benedikt/heichips26-FAIf/macros/heichips26_FAIf/macros/aswitch/schematic/xschem/aswitch.sym
** sch_path: /home/benedikt/heichips26-FAIf/macros/heichips26_FAIf/macros/aswitch/schematic/xschem/aswitch.sch
.subckt aswitch sw_b VDD b a VSS sw
*.iopin a
*.iopin sw_b
*.iopin b
*.iopin sw
*.iopin VDD
*.iopin VSS
XM1 a sw b VSS sg13_hv_nmos w=4u l=0.6u ng=2 m=1 mm_ok=1
XM2 a sw_b b VDD sg13_hv_pmos w=14u l=0.6u ng=2 m=1 mm_ok=1
XM1Dummyb a sw_b a VSS sg13_hv_nmos w=2u l=0.6u ng=1 m=1 mm_ok=1
XM3 b sw_b b VSS sg13_hv_nmos w=2u l=0.6u ng=1 m=1 mm_ok=1
XM4 a sw a VDD sg13_hv_pmos w=7u l=0.6u ng=1 m=1 mm_ok=1
XM5 b sw b VDD sg13_hv_pmos w=7u l=0.6u ng=1 m=1 mm_ok=1
.ends

.end
