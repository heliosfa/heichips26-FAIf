** sch_path: /home/gfcwfzkm/eda/designs/heichips26-FAIf/macros/heichips26_analog_project/macros/r2r_dac/schematic/xschem/r2r_dac.sch
.subckt r2r_dac PDACVDD ODACOUT IDACVTAP IDACIREF nD7 nD0 nD2 nD4 nD5 nD6 nD3 nD1 PDACVSS IDACDISABLE
*.PININFO PDACVDD:B PDACVSS:B nD0:I nD1:I nD2:I IDACIREF:I ODACOUT:O nD3:I nD4:I nD5:I nD6:I nD7:I IDACVTAP:I IDACDISABLE:I
XR1 net1 PDACVSS PDACVSS rhigh w=0.5e-6 l=15e-6 m=1 b=0 mm_ok=1
XR2 net8 net1 PDACVSS rhigh w=0.5e-6 l=15e-6 m=1 b=0 mm_ok=1
XR4 net2 nD0 PDACVSS rhigh w=0.5e-6 l=15e-6 m=1 b=0 mm_ok=1
XR5 net7 net2 PDACVSS rhigh w=0.5e-6 l=15e-6 m=1 b=0 mm_ok=1
XR6 net3 nD1 PDACVSS rhigh w=0.5e-6 l=15e-6 m=1 b=0 mm_ok=1
XR7 net6 net3 PDACVSS rhigh w=0.5e-6 l=15e-6 m=1 b=0 mm_ok=1
XR8 net4 nD2 PDACVSS rhigh w=0.5e-6 l=15e-6 m=1 b=0 mm_ok=1
XR9 net5 net4 PDACVSS rhigh w=0.5e-6 l=15e-6 m=1 b=0 mm_ok=1
XR10 net7 net8 PDACVSS rhigh w=0.5e-6 l=15e-6 m=1 b=0 mm_ok=1
XR11 net6 net7 PDACVSS rhigh w=0.5e-6 l=15e-6 m=1 b=0 mm_ok=1
XR12 net5 net6 PDACVSS rhigh w=0.5e-6 l=15e-6 m=1 b=0 mm_ok=1
XR14 UNBUF_DAC net9 PDACVSS rhigh w=0.5e-6 l=14e-6 m=1 b=0 mm_ok=1
XR3 net10 nD3 PDACVSS rhigh w=0.5e-6 l=15e-6 m=1 b=0 mm_ok=1
XR13 net13 net10 PDACVSS rhigh w=0.5e-6 l=15e-6 m=1 b=0 mm_ok=1
XR15 net11 nD4 PDACVSS rhigh w=0.5e-6 l=15e-6 m=1 b=0 mm_ok=1
XR16 net12 net11 PDACVSS rhigh w=0.5e-6 l=15e-6 m=1 b=0 mm_ok=1
XR17 net13 net5 PDACVSS rhigh w=0.5e-6 l=15e-6 m=1 b=0 mm_ok=1
XR18 net12 net13 PDACVSS rhigh w=0.5e-6 l=15e-6 m=1 b=0 mm_ok=1
XR19 net14 nD5 PDACVSS rhigh w=0.5e-6 l=15e-6 m=1 b=0 mm_ok=1
XR20 net17 net14 PDACVSS rhigh w=0.5e-6 l=15e-6 m=1 b=0 mm_ok=1
XR21 net15 nD6 PDACVSS rhigh w=0.5e-6 l=15e-6 m=1 b=0 mm_ok=1
XR22 net16 net15 PDACVSS rhigh w=0.5e-6 l=15e-6 m=1 b=0 mm_ok=1
XR23 net17 net12 PDACVSS rhigh w=0.5e-6 l=15e-6 m=1 b=0 mm_ok=1
XR24 net16 net17 PDACVSS rhigh w=0.5e-6 l=15e-6 m=1 b=0 mm_ok=1
XR25 net18 nD7 PDACVSS rhigh w=0.5e-6 l=15e-6 m=1 b=0 mm_ok=1
XR26 UNBUF_DAC net18 PDACVSS rhigh w=0.5e-6 l=15e-6 m=1 b=0 mm_ok=1
XR27 UNBUF_DAC net16 PDACVSS rhigh w=0.5e-6 l=15e-6 m=1 b=0 mm_ok=1
x1 PDACVDD IDACIREF UNBUF_DAC ODACOUT IDACVTAP PDACVSS IDACDISABLE op_amp_ver_2
XM1 net9 nIDACDISABLE ODACOUT PDACVSS sg13_hv_nmos w=1u l=0.45u ng=1 m=1 mm_ok=1
XM2 ODACOUT IDACDISABLE net9 PDACVDD sg13_hv_pmos w=2u l=0.45u ng=1 m=1 mm_ok=1
XRD2 PDACVSS PDACVSS PDACVSS rhigh w=0.5e-6 l=15e-6 m=1 b=0 mm_ok=1
XRD1 PDACVSS PDACVSS PDACVSS rhigh w=0.5e-6 l=15e-6 m=1 b=0 mm_ok=1
XRD3 PDACVSS PDACVSS PDACVSS rhigh w=0.5e-6 l=14e-6 m=1 b=0 mm_ok=1
XM3 nIDACDISABLE IDACDISABLE PDACVSS PDACVSS sg13_hv_nmos w=0.3u l=0.45u ng=1 m=1 mm_ok=1
XM4 nIDACDISABLE IDACDISABLE PDACVDD PDACVDD sg13_hv_pmos w=0.6u l=0.45u ng=1 m=1 mm_ok=1
.ends

* expanding   symbol:  ../../../opamp/schematic/xschem/op_amp_ver_2.sym # of pins=7
** sym_path: /home/gfcwfzkm/eda/designs/heichips26-FAIf/macros/heichips26_analog_project/macros/r2r_dac/schematic/xschem/../../../opamp/schematic/xschem/op_amp_ver_2.sym
** sch_path: /home/gfcwfzkm/eda/designs/heichips26-FAIf/macros/heichips26_analog_project/macros/r2r_dac/schematic/xschem/../../../opamp/schematic/xschem/op_amp_ver_2.sch
.subckt op_amp_ver_2 POAVDD IOAIREF IOAM OOA IOAP POAVSS IOADISABLE
*.PININFO POAVDD:B IOAM:I IOAP:I OOA:O IOAIREF:I POAVSS:B IOADISABLE:I
XMP13 net1 net1 POAVDD POAVDD sg13_hv_pmos w=2.4u l=0.4u ng=1 m=1 mm_ok=1
XMP14 ptlg ptlg net1 POAVDD sg13_hv_pmos w=2.4u l=0.4u ng=1 m=1 mm_ok=1
XMN16 ptlg ncasc net2 POAVSS sg13_hv_nmos w=0.6u l=0.6u ng=1 m=1 mm_ok=1
XMN13 net2 nbias POAVSS POAVSS sg13_hv_nmos w=0.6u l=2.4u ng=1 m=1 mm_ok=1
XMN18 ntlg ntlg net3 POAVSS sg13_hv_nmos w=1.2u l=0.6u ng=1 m=1 mm_ok=1
XMN17 net3 net3 POAVSS POAVSS sg13_hv_nmos w=1.2u l=0.6u ng=1 m=1 mm_ok=1
XMP10 net11 pbias POAVDD POAVDD sg13_hv_pmos w=1.2u l=1.2u ng=1 m=1 mm_ok=1
XMP12 ntlg pcasc net11 POAVDD sg13_hv_pmos w=1.2u l=0.6u ng=1 m=1 mm_ok=1
XMP1 net9 pbias POAVDD POAVDD sg13_hv_pmos w=1.2u l=1.2u ng=1 m=4 mm_ok=1
XMP2 net10 pbias POAVDD POAVDD sg13_hv_pmos w=1.2u l=1.2u ng=1 m=4 mm_ok=1
XMN1 net9 IOAM net5 POAVSS sg13_hv_nmos w=4.8u l=0.45u ng=1 m=1 mm_ok=1
XMN2 net10 IOAP net5 POAVSS sg13_hv_nmos w=4.8u l=0.45u ng=1 m=1 mm_ok=1
XMN3 net4 nbias POAVSS POAVSS sg13_hv_nmos w=0.6u l=2.4u ng=1 m=8 mm_ok=1
XMN6 net5 ncasc net4 POAVSS sg13_hv_nmos w=0.6u l=0.6u ng=1 m=8 mm_ok=1
XMN7 net8 ncasc net7 POAVSS sg13_hv_nmos w=0.6u l=0.6u ng=1 m=8 mm_ok=1
XMN8 ndrive ncasc net6 POAVSS sg13_hv_nmos w=0.6u l=0.6u ng=1 m=8 mm_ok=1
XMN4 net7 net8 POAVSS POAVSS sg13_hv_nmos w=0.6u l=2.4u ng=1 m=8 mm_ok=1
XMN5 net6 net8 POAVSS POAVSS sg13_hv_nmos w=0.6u l=2.4u ng=1 m=8 mm_ok=1
XMP3 net9 pbias POAVDD POAVDD sg13_hv_pmos w=1.2u l=1.2u ng=1 m=4 mm_ok=1
XMP5 net8 pcasc net9 POAVDD sg13_hv_pmos w=1.2u l=0.6u ng=1 m=8 mm_ok=1
XMP4 net10 pbias POAVDD POAVDD sg13_hv_pmos w=1.2u l=1.2u ng=1 m=4 mm_ok=1
XMP6 pdrive pcasc net10 POAVDD sg13_hv_pmos w=1.2u l=0.6u ng=1 m=8 mm_ok=1
XMP7 ndrive ptlg pdrive POAVDD sg13_hv_pmos w=2.4u l=0.4u ng=1 m=4 mm_ok=1
XMN9 pdrive ntlg ndrive POAVSS sg13_hv_nmos w=1.2u l=0.6u ng=1 m=4 mm_ok=1
XMP8 OOA pdrive POAVDD POAVDD sg13_hv_pmos w=2.4u l=0.4u ng=1 m=40 mm_ok=1
XMN10 OOA ndrive POAVSS POAVSS sg13_hv_nmos w=1.2u l=0.6u ng=1 m=40 mm_ok=1
XMN20 IOAIREF IOAIREF POAVSS POAVSS sg13_hv_nmos w=0.6u l=2.4u ng=1 m=1 mm_ok=1
XMN21 pcasc IOAIREF POAVSS POAVSS sg13_hv_nmos w=0.6u l=2.4u ng=1 m=1 mm_ok=1
XMN22 pbias IOAIREF POAVSS POAVSS sg13_hv_nmos w=0.6u l=2.4u ng=1 m=1 mm_ok=1
XMN23 net19 ncasc POAVSS POAVSS sg13_hv_nmos w=0.4u l=10u ng=1 m=1 mm_ok=1
XMN25 net13 nbias POAVSS POAVSS sg13_hv_nmos w=0.6u l=2.4u ng=1 m=1 mm_ok=1
XMN24 ncasc ncasc net22 POAVSS sg13_hv_nmos w=0.4u l=10u ng=1 m=1 mm_ok=1
XMN26 nbias ncasc net13 POAVSS sg13_hv_nmos w=0.6u l=0.6u ng=1 m=1 mm_ok=1
XMP21 pcasc pcasc net18 POAVDD sg13_hv_pmos w=1u l=10u ng=1 m=1 mm_ok=1
XMP20 net18 pcasc net17 POAVDD sg13_hv_pmos w=1u l=10.0u ng=1 m=1 mm_ok=1
XMP22 net12 pbias POAVDD POAVDD sg13_hv_pmos w=1.2u l=1.2u ng=1 m=1 mm_ok=1
XMP25 pbias pcasc net12 POAVDD sg13_hv_pmos w=1.2u l=0.6u ng=1 m=1 mm_ok=1
XMP26 ncasc pcasc net15 POAVDD sg13_hv_pmos w=1.2u l=0.6u ng=1 m=1 mm_ok=1
XMP23 net15 pbias POAVDD POAVDD sg13_hv_pmos w=1.2u l=1.2u ng=1 m=1 mm_ok=1
XMP24 net14 pbias POAVDD POAVDD sg13_hv_pmos w=1.2u l=1.2u ng=1 m=1 mm_ok=1
XMP27 nbias pcasc net14 POAVDD sg13_hv_pmos w=1.2u l=0.6u ng=1 m=1 mm_ok=1
XMP16 net17 pcasc net16 POAVDD sg13_hv_pmos w=1u l=10.0u ng=1 m=1 mm_ok=1
XMN11 net20 ncasc net19 POAVSS sg13_hv_nmos w=0.4u l=10u ng=1 m=1 mm_ok=1
XMP28 net16 pcasc POAVDD POAVDD sg13_hv_pmos w=1u l=10.0u ng=1 m=1 mm_ok=1
XMN12 net21 ncasc net20 POAVSS sg13_hv_nmos w=0.4u l=10u ng=1 m=1 mm_ok=1
XMN14 net22 ncasc net21 POAVSS sg13_hv_nmos w=0.4u l=10u ng=1 m=1 mm_ok=1
XMDP1 POAVDD pbias POAVDD POAVDD sg13_hv_pmos w=1.2u l=1.2u ng=1 m=1 mm_ok=1
XMDP2 POAVDD pbias POAVDD POAVDD sg13_hv_pmos w=1.2u l=1.2u ng=1 m=1 mm_ok=1
XMDOP1 POAVDD pcasc POAVDD POAVDD sg13_hv_pmos w=1.2u l=0.6u ng=1 m=1 mm_ok=1
XMDOP2 POAVDD pcasc POAVDD POAVDD sg13_hv_pmos w=1.2u l=0.6u ng=1 m=1 mm_ok=1
XMDOP3 POAVDD pcasc POAVDD POAVDD sg13_hv_pmos w=1.2u l=0.6u ng=1 m=1 mm_ok=1
XMDOP4 POAVDD pcasc POAVDD POAVDD sg13_hv_pmos w=1.2u l=0.6u ng=1 m=1 mm_ok=1
XMDN1 POAVSS nbias POAVSS POAVSS sg13_hv_nmos w=0.6u l=2.4u ng=1 m=1 mm_ok=1
XMDN2 POAVSS nbias POAVSS POAVSS sg13_hv_nmos w=0.6u l=2.4u ng=1 m=1 mm_ok=1
XMDON1 nIOADISABLE IOADISABLE POAVSS POAVSS sg13_hv_nmos w=0.6u l=0.6u ng=1 m=1 mm_ok=1
XMDON2 ntlg IOADISABLE POAVSS POAVSS sg13_hv_nmos w=0.6u l=0.6u ng=1 m=1 mm_ok=1
XMDON3 ndrive IOADISABLE POAVSS POAVSS sg13_hv_nmos w=0.6u l=0.6u ng=1 m=1 mm_ok=1
XMDON4 IOAIREF IOADISABLE POAVSS POAVSS sg13_hv_nmos w=0.6u l=0.6u ng=1 m=1 mm_ok=1
XMDP7 POAVDD pbias POAVDD POAVDD sg13_hv_pmos w=1.2u l=1.2u ng=1 m=1 mm_ok=1
XMDP8 POAVDD pbias POAVDD POAVDD sg13_hv_pmos w=1.2u l=1.2u ng=1 m=1 mm_ok=1
XMDN7 POAVSS nbias POAVSS POAVSS sg13_hv_nmos w=0.6u l=2.4u ng=1 m=1 mm_ok=1
XMDN8 POAVSS nbias POAVSS POAVSS sg13_hv_nmos w=0.6u l=2.4u ng=1 m=1 mm_ok=1
XMDN9 POAVSS POAVSS POAVSS POAVSS sg13_hv_nmos w=1.2u l=0.45u ng=1 m=1 mm_ok=1
XMDN10 POAVSS POAVSS POAVSS POAVSS sg13_hv_nmos w=1.2u l=0.45u ng=1 m=1 mm_ok=1
XMDN11 POAVSS POAVSS POAVSS POAVSS sg13_hv_nmos w=1.2u l=0.45u ng=1 m=1 mm_ok=1
XMDN12 POAVSS POAVSS POAVSS POAVSS sg13_hv_nmos w=1.2u l=0.45u ng=1 m=1 mm_ok=1
XMDN13 POAVSS POAVSS POAVSS POAVSS sg13_hv_nmos w=2.4u l=0.45u ng=1 m=1 mm_ok=1
XMDN14 POAVSS POAVSS POAVSS POAVSS sg13_hv_nmos w=2.4u l=0.45u ng=1 m=1 mm_ok=1
XMDN15 POAVSS POAVSS POAVSS POAVSS sg13_hv_nmos w=2.4u l=0.45u ng=1 m=1 mm_ok=1
XMDN16 POAVSS POAVSS POAVSS POAVSS sg13_hv_nmos w=2.4u l=0.45u ng=1 m=1 mm_ok=1
XMDN17 POAVSS POAVSS POAVSS POAVSS sg13_hv_nmos w=1.2u l=0.45u ng=1 m=1 mm_ok=1
XMDN18 POAVSS POAVSS POAVSS POAVSS sg13_hv_nmos w=1.2u l=0.45u ng=1 m=1 mm_ok=1
XMDN19 POAVSS POAVSS POAVSS POAVSS sg13_hv_nmos w=1.2u l=0.45u ng=1 m=1 mm_ok=1
XMDN20 POAVSS POAVSS POAVSS POAVSS sg13_hv_nmos w=1.2u l=0.45u ng=1 m=1 mm_ok=1
XMDN21 POAVSS IOAIREF POAVSS POAVSS sg13_hv_nmos w=0.6u l=2.4u ng=1 m=1 mm_ok=1
XMDN22 POAVSS IOAIREF POAVSS POAVSS sg13_hv_nmos w=0.6u l=2.4u ng=1 m=1 mm_ok=1
XMDP9 POAVDD pcasc POAVDD POAVDD sg13_hv_pmos w=1u l=10u ng=1 m=1 mm_ok=1
XMDN23 POAVSS ncasc POAVSS POAVSS sg13_hv_nmos w=0.4u l=10u ng=1 m=1 mm_ok=1
XMDP10 POAVDD pcasc POAVDD POAVDD sg13_hv_pmos w=1u l=10u ng=1 m=1 mm_ok=1
XMDN24 POAVSS ncasc POAVSS POAVSS sg13_hv_nmos w=0.4u l=10u ng=1 m=1 mm_ok=1
XMDP11 POAVDD pbias POAVDD POAVDD sg13_hv_pmos w=1.2u l=1.2u ng=1 m=1 mm_ok=1
XMDP12 POAVDD pbias POAVDD POAVDD sg13_hv_pmos w=1.2u l=1.2u ng=1 m=1 mm_ok=1
XMDP13 POAVDD pcasc POAVDD POAVDD sg13_hv_pmos w=1.2u l=0.6u ng=1 m=1 mm_ok=1
XMDP14 POAVDD pcasc POAVDD POAVDD sg13_hv_pmos w=1.2u l=0.6u ng=1 m=1 mm_ok=1
XMDN25 POAVSS POAVSS POAVSS POAVSS sg13_hv_nmos w=0.6u l=2.4u ng=1 m=1 mm_ok=1
XMDN26 POAVSS POAVSS POAVSS POAVSS sg13_hv_nmos w=0.6u l=2.4u ng=1 m=1 mm_ok=1
XMDN27 POAVSS ncasc POAVSS POAVSS sg13_hv_nmos w=0.6u l=0.6u ng=1 m=1 mm_ok=1
XMDN28 POAVSS ncasc POAVSS POAVSS sg13_hv_nmos w=0.6u l=0.6u ng=1 m=1 mm_ok=1
XMDP15 POAVDD POAVDD POAVDD POAVDD sg13_hv_pmos w=2.4u l=0.4u ng=1 m=8 mm_ok=1
XMDN29 POAVSS POAVSS POAVSS POAVSS sg13_hv_nmos w=1.2u l=0.6u ng=1 m=8 mm_ok=1
XMDP16 POAVDD POAVDD POAVDD POAVDD sg13_hv_pmos w=2.4u l=0.4u ng=1 m=2 mm_ok=1
XMDN30 POAVSS POAVSS POAVSS POAVSS sg13_hv_nmos w=1.2u l=0.6u ng=1 m=2 mm_ok=1
XMDP17 POAVDD POAVDD POAVDD POAVDD sg13_hv_pmos w=2.4u l=0.4u ng=1 m=8 mm_ok=1
XMDN31 POAVSS POAVSS POAVSS POAVSS sg13_hv_nmos w=1.2u l=0.6u ng=1 m=8 mm_ok=1
XMDOP5 nIOADISABLE IOADISABLE POAVDD POAVDD sg13_hv_pmos w=1.2u l=0.6u ng=1 m=1 mm_ok=1
XMDOP6 ptlg nIOADISABLE POAVDD POAVDD sg13_hv_pmos w=1.2u l=0.6u ng=1 m=1 mm_ok=1
XMDOP7 pdrive nIOADISABLE POAVDD POAVDD sg13_hv_pmos w=1.2u l=0.6u ng=1 m=1 mm_ok=1
XMDOP8 pcasc nIOADISABLE POAVDD POAVDD sg13_hv_pmos w=1.2u l=0.6u ng=1 m=1 mm_ok=1
.ends
