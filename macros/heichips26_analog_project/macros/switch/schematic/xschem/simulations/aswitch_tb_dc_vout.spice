** sch_path: /home/benedikt/heichips26-FAIf/macros/heichips26_analog_project/macros/aswitch/testbenches/xschem/aswitch_tb_dc_vout.sch
**.subckt aswitch_tb_dc_vout
VDD VDD GND {VDD}
Vgsp vin GND 0
x4 GND VDD vout vin GND VDD aswitch
V1 vin vout 1m
.save i(v1)
**** begin user architecture code

* .include ../../../netlist/pex/inverter_magic_pex_3.spice
.param VDD=3.3
.csparam VDD=VDD
.param Vcm=VDD/2
.csparam Vcm=Vcm
.param temp=27
.param Cload=10p
.param Rload=1k
.options savecurrents klu method=gear reltol=1e-3 abstol=1e-15 gmin=1e-15
.control

save all

* Operating Point Analysis
op
remzerovec
write aswitch_tb_dc_vout.raw
set appendwrite

* DC Sweep
dc Vgsp 0 $&VDD 1m
remzerovec
write aswitch_tb_dc_vout.raw
set appendwrite

* Plotting
plot vin vout
plot i(v1)

* Measurement
meas dc Vgsp_at_Vcm when vout=Vcm
print Vgsp_at_Vcm

* Write Data
unset appendwrite
set wr_vecnames
set wr_singlescale
wrdata ../plot_simulations/data/aswitch_tb_dc_vout.txt v(vin) v(vout)

*quit
.endc

.lib cornerMOSlv.lib mos_tt
.lib cornerMOShv.lib mos_tt
.lib cornerRES.lib res_typ
.lib cornerDIO.lib dio_tt

**** end user architecture code
**.ends

* expanding   symbol:  aswitch.sym # of pins=6
** sym_path: /home/benedikt/heichips26-FAIf/macros/heichips26_analog_project/macros/aswitch/schematic/xschem/aswitch.sym
** sch_path: /home/benedikt/heichips26-FAIf/macros/heichips26_analog_project/macros/aswitch/schematic/xschem/aswitch.sch
.subckt aswitch sw_b VDD b a VSS sw
*.iopin a
*.iopin sw_b
*.iopin b
*.iopin sw
*.iopin VDD
*.iopin VSS
XM1 a sw b VSS sg13_hv_nmos w=4u l=0.6u ng=1 m=1 mm_ok=1
XM2 a sw_b b VDD sg13_hv_pmos w=14u l=0.6u ng=2 m=1 mm_ok=1
.ends

.GLOBAL GND
.GLOBAL VDD
.end
